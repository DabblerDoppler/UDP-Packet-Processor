[IBIS Ver]   4.2
[File Name]  header_parser.ibs
[File Rev]   3.0
[Date]   May 12, 2025
[Source]   Altera Corporation
[Notes]   - The models are designated as "Final" and have been correlated against physical device operation.
   - This IBIS model is checked using IBISCHK v5.0.4
   There are no known errors and warnings reported.
   - There are no known limitations for this IBIS model release.
   - Contact point: Altera Corporation, http://www.altera.com/corporate/contact/con-index.html
   - This file is generated using Quartus II Version 24.1std.0 Build 1077 03/04/2025 SC Standard Edition
   - Unused IOs which have been assigned as tri-stated inputs or as outputs driving any signal in Quartus II
   arerepresented by the NC.
   - Only general purpose IBIS models are supported.
   Revision History
   - v1.0
   - Initial release of Arria 10 IBIS models. Models are based on pre-layout and early engineering info.
   - v2.0
   - Models are based on post-layout, may be missing certain features.
   - v3.0
   - Models have undergone final correlation against physical device operation.
[Disclaimer] Data is for modeling purposes only and is not guaranteed.
[Copyright]  Copyright (C) 2025  Altera Corporation. All rights reserved.
[Component]  10AX115S2F45I2SG_header_parser
[Manufacturer] Altera Corporation
[Package]
| RLC values are for 1932 FBGA package
| variable  typ   min   max
R_pkg   1801m   705m   3310m
L_pkg   7.78nH   3.66nH   14.38nH
C_pkg   3.89pF   1.77pF   6.27pF
[Pin] signal_name   model_name   R_pin   L_pin   C_pin
A11   GND   GND
A12   out_data[207]   18_rtio_r50_lv   2005.4m  8.709nH   4.419pF
A13   out_keep[13]   18_rtio_r50_lv   1929.9m  8.239nH   4.348pF
A14   out_keep[12]   18_rtio_r50_lv   2026.6m  8.834nH   4.306pF
A15   out_data[210]   18_rtio_r50_lv   1997.6m  8.376nH   4.291pF
A16   GND   GND
A17   out_data[236]   18_rtio_r50_lv   2043.5m  8.360nH   4.515pF
A18   out_data[239]   18_rtio_r50_lv   2078.9m  8.697nH   4.584pF
A19   out_data[20]   18_rtio_r50_lv   1349.1m  5.715nH   3.400pF
A2   GND   GND
A20   in_data[137]   18_rtin_lv   1335.2m  5.715nH   3.386pF
A21   GND   GND
A22   out_data[6]   18_rtio_r50_lv   1368.6m  6.012nH   3.376pF
A23   out_data[4]   18_rtio_r50_lv   1455.4m  6.486nH   3.588pF
A24   out_data[8]   18_rtio_r50_lv   1473.1m  6.241nH   3.606pF
A25   out_data[5]   18_rtio_r50_lv   1485.7m  6.336nH   3.583pF
A26   GND   GND
A27   out_data[42]   18_rtio_r50_lv   1339.7m  5.876nH   3.340pF
A28   out_data[46]   18_rtio_r50_lv   1348.1m  5.833nH   3.413pF
A29   out_data[38]   18_rtio_r50_lv   1488.5m  6.591nH   3.527pF
A30   out_data[37]   18_rtio_r50_lv   1496.4m  6.543nH   3.612pF
A31   GND   GND
A32   in_keep[2]   18_rtin_lv   1676.7m  7.346nH   3.834pF
A33   in_keep[19]   18_rtin_lv   1733.1m  7.417nH   3.999pF
A34   GND   GND
A36   GND   GND
A39   GND   GND
A40   GND   GND
A43   GND   GND
A5   GND   GND
A6   GND   GND
A9   GND   GND
AA1   GND   GND
AA10  GND   GND
AA11  GND   GND
AA12  VREFB3EN0   POWER
AA13  in_data[108]   18_rtin_lv   2952.2m  13.531nH  5.651pF
AA14  in_data[88]   18_rtin_lv   2970.3m  12.948nH  5.726pF
AA15  VCC   POWER
AA16  GND   GND
AA17  VCC   POWER
AA18  VCC   POWER
AA19  VCC   POWER
AA2   GND   GND
AA20  VCC   POWER
AA21  GND   GND
AA22  VCC   POWER
AA23  VCC   POWER
AA24  VCC   POWER
AA25  VCC   POWER
AA26  GND   GND
AA27  VCC   POWER
AA28  VCC   POWER
AA29  VCC   POWER
AA30  out_data[230]   18_rtio_r50_lv   2292.5m  10.152nH  4.708pF
AA31  VCCIO2J   POWER
AA32  out_data[231]   18_rtio_r50_lv   2418.6m  10.166nH  4.680pF
AA33  timestamp[27]   18_rtio_r50_lv   2483.5m  10.744nH  4.498pF
AA34  timestamp[29]   18_rtio_r50_lv   2467.5m  10.794nH  4.578pF
AA35  GND   GND
AA36  GND   GND
AA39  GND   GND
AA40  GND   GND
AA43  GND   GND
AA44  GND   GND
AA5   GND   GND
AA6   GND   GND
AA9   GND   GND
AB10  GND   GND
AB11  in_data[63]   18_rtin_lv   3033.4m  13.484nH  5.876pF
AB12  in_data[126]   18_rtin_lv   3033.4m  13.087nH  5.451pF
AB13  in_data[79]   18_rtin_lv   2947.8m  13.544nH  5.610pF
AB14  VCCIO3E   POWER
AB15  VCC   POWER
AB16  VCC   POWER
AB17  VCC   POWER
AB18  VCC   POWER
AB19  GND   GND
AB20  VCC   POWER
AB21  VCC   POWER
AB22  VCCA_PLL   POWER
AB23  VCCA_PLL   POWER
AB24  GND   GND
AB25  VCC   POWER
AB26  VCC   POWER
AB27  VCC   POWER
AB28  VCC   POWER
AB29  GND   GND
AB3   GND   GND
AB30  VREFB2JN0   POWER
AB31  out_data[228]   18_rtio_r50_lv   2668.7m  11.117nH  5.425pF
AB32  out_keep[1]   18_rtio_r50_lv   2697.7m  11.313nH  5.071pF
AB33  out_keep[5]   18_rtio_r50_lv   2742.2m  12.618nH  5.362pF
AB34  GND   GND
AB35  GND   GND
AB36  VCCH_GXBL   POWER
AB37  VCCT_GXBL1E   POWER
AB38  VCCT_GXBL1E   POWER
AB4   GND   GND
AB41  GND   GND
AB42  GND   GND
AB7   VCCT_GXBR4E   POWER
AB8   VCCT_GXBR4E   POWER
AB9   VCCH_GXBR   POWER
AC1   GND   GND
AC10  GND   GND
AC11  in_data[104]   18_rtin_lv   3062.5m  13.511nH  5.863pF
AC12  VCCIO3D   POWER
AC13  in_data[75]   18_rtin_lv   2971.2m  13.045nH  5.743pF
AC14  VCC   POWER
AC15  VCCERAM   POWER
AC16  VCCERAM   POWER
AC17  GND   GND
AC18  VCCERAM   POWER
AC19  VCC   POWER
AC2   GND   GND
AC20  VCC   POWER
AC21  VCCERAM   POWER
AC22  GND   GND
AC23  VCCERAM   POWER
AC24  VCC   POWER
AC25  VCC   POWER
AC26  VCCERAM   POWER
AC27  GND   GND
AC28  VCCERAM   POWER
AC29  VCCERAM   POWER
AC30  VCC   POWER
AC31  timestamp[25]   18_rtio_r50_lv   2526.9m  10.365nH  5.241pF
AC32  GND   GND
AC33  out_data[192]   18_rtio_r50_lv   2770.4m  12.462nH  5.491pF
AC34  out_data[193]   18_rtio_r50_lv   2503.4m  11.428nH  4.933pF
AC35  GND   GND
AC36  GND   GND
AC39  GND   GND
AC40  GND   GND
AC43  GND   GND
AC44  GND   GND
AC5   GND   GND
AC6   GND   GND
AC9   GND   GND
AD10  GND   GND
AD11  VREFB3DN0   POWER
AD12  out_data[104]   18_rtio_r50_lv   2907.3m  12.352nH  5.416pF
AD13  in_data[124]   18_rtin_lv   3300.2m  13.943nH  6.192pF
AD14  in_data[80]   18_rtin_lv   3300.6m  14.159nH  6.128pF
AD15  VCCIO3D   POWER
AD16  VCC   POWER
AD17  VCC   POWER
AD18  VCC   POWER
AD19  VCC   POWER
AD20  GND   GND
AD21  VCC   POWER
AD22  VCC   POWER
AD23  VCC   POWER
AD24  VCC   POWER
AD25  GND   GND
AD26  VCC   POWER
AD27  VCC   POWER
AD28  VCC   POWER
AD29  VCC   POWER
AD3   GND   GND
AD30  VCCIO2J   POWER
AD31  out_data[187]   18_rtio_r50_lv   2553.2m  10.680nH  5.267pF
AD32  out_data[191]   18_rtio_r50_lv   2861.0m  12.127nH  5.721pF
AD33  out_data[190]   18_rtio_r50_lv   2893.9m  12.107nH  5.704pF
AD34  timestamp[28]   18_rtio_r50_lv   2512.7m  10.765nH  5.039pF
AD35  out_data[197]   18_rtio_r50_lv   3083.9m  13.228nH  5.492pF
AD36  GND   GND
AD37  VCCR_GXBL1E   POWER
AD38  VCCR_GXBL1E   POWER
AD4   GND   GND
AD41  GND   GND
AD42  GND   GND
AD7   VCCR_GXBR4E   POWER
AD8   VCCR_GXBR4E   POWER
AD9   GND   GND
AE1   GND   GND
AE10  GND   GND
AE11  out_data[92]   18_rtio_r50_lv   2912.0m  12.541nH  5.336pF
AE12  out_data[129]   18_rtio_r50_lv   2590.3m  10.956nH  5.205pF
AE13  VCCIO3D   POWER
AE14  out_data[89]   18_rtio_r50_lv   2030.9m  8.866nH   4.168pF
AE15  out_data[109]   18_rtio_r50_lv   2080.3m  9.784nH   4.016pF
AE16  VCC   POWER
AE17  VCC   POWER
AE18  GND   GND
AE19  VCC   POWER
AE2   GND   GND
AE20  VCC   POWER
AE21  VCC   POWER
AE22  VCC   POWER
AE23  GND   GND
AE24  VCC   POWER
AE25  VCC   POWER
AE26  VCC   POWER
AE27  VCC   POWER
AE28  GND   GND
AE29  VCC   POWER
AE30  out_keep[2]   18_rtio_r50_lv   2993.5m  12.527nH  5.787pF
AE31  timestamp[26]   18_rtio_r50_lv   2781.3m  12.024nH  5.479pF
AE32  out_data[226]   18_rtio_r50_lv   2747.5m  12.023nH  5.418pF
AE33  GND   GND
AE34  out_data[194]   18_rtio_r50_lv   3065.0m  12.863nH  5.947pF
AE35  GND   GND
AE36  GND   GND
AE39  GND   GND
AE40  GND   GND
AE43  GND   GND
AE44  GND   GND
AE5   GND   GND
AE6   GND   GND
AE9   GND   GND
AF10  GND   GND
AF11  GND   GND
AF12  out_data[103]   18_rtio_r50_lv   2619.2m  11.129nH  5.281pF
AF13  out_data[87]   18_rtio_r50_lv   2668.0m  10.859nH  4.939pF
AF14  out_data[127]   18_rtio_r50_lv   2928.3m  11.826nH  5.696pF
AF15  out_data[101]   18_rtio_r50_lv   2901.6m  11.955nH  5.678pF
AF16  GND   GND
AF17  VCC   POWER
AF18  VCC   POWER
AF19  VCC   POWER
AF20  VCC   POWER
AF21  GND   GND
AF24  VCC   POWER
AF25  VCC   POWER
AF26  GND   GND
AF27  VCC   POWER
AF28  VCC   POWER
AF29  VCC   POWER
AF3   GND   GND
AF30  out_keep[6]   18_rtio_r50_lv   2968.5m  12.493nH  5.833pF
AF31  GND   GND
AF32  out_data[185]   18_rtio_r50_lv   2269.5m  10.373nH  4.733pF
AF33  out_data[225]   18_rtio_r50_lv   3223.1m  13.716nH  6.191pF
AF34  out_data[196]   18_rtio_r50_lv   3310.1m  14.023nH  6.271pF
AF35  GND   GND
AF36  VCCH_GXBL   POWER
AF37  VCCT_GXBL1D   POWER
AF38  VCCT_GXBL1D   POWER
AF4   GND   GND
AF41  GND   GND
AF42  GND   GND
AF7   VCCT_GXBR4D   POWER
AF8   VCCT_GXBR4D   POWER
AF9   VCCH_GXBR   POWER
AG1   GND   GND
AG10  GND   GND
AG11  out_data[115]   18_rtio_r50_lv   2333.2m  10.679nH  4.383pF
AG12  out_data[107]   18_rtio_r50_lv   2335.2m  10.286nH  4.510pF
AG13  out_data[88]   18_rtio_r50_lv   2686.8m  11.604nH  4.893pF
AG14  GND   GND
AG15  VCCP   POWER
AG16  VCC   POWER
AG17  VCC   POWER
AG18  VCC   POWER
AG19  GND   GND
AG2   GND   GND
AG20  VCCP   POWER
AG21  VCCP   POWER
AG22  VCC   POWER
AG23  VCC   POWER
AG24  GND   GND
AG25  VCCP   POWER
AG26  VCC   POWER
AG27  VCC   POWER
AG28  VCC   POWER
AG29  GND   GND
AG30  VCCP   POWER
AG31  out_data[183]   18_rtio_r50_lv   3004.4m  12.239nH  5.879pF
AG32  out_data[199]   18_rtio_r50_lv   2290.9m  10.294nH  4.814pF
AG33  out_keep[0]   18_rtio_r50_lv   3020.1m  12.526nH  5.455pF
AG34  GND   GND
AG35  GND   GND
AG36  GND   GND
AG39  GND   GND
AG40  GND   GND
AG43  GND   GND
AG44  GND   GND
AG5   GND   GND
AG6   GND   GND
AG9   GND   GND
AH10  out_data[128]   18_rtio_r50_lv   3013.3m  12.318nH  5.795pF
AH11  out_data[112]   18_rtio_r50_lv   3037.1m  12.497nH  5.866pF
AH12  GND   GND
AH13  out_data[106]   18_rtio_r50_lv   3015.1m  12.313nH  5.840pF
AH14  out_data[98]   18_rtio_r50_lv   2985.7m  12.000nH  5.857pF
AH15  VCCP   POWER
AH16  VCCPT   POWER
AH17  GND   GND
AH18  VCC   POWER
AH19  VCCPT   POWER
AH20  VCCP   POWER
AH21  VCCPT   POWER
AH22  GND   GND
AH23  VCC   POWER
AH24  VCC   POWER
AH25  VCCPT   POWER
AH26  VCC   POWER
AH27  GND   GND
AH28  VCCPT   POWER
AH29  VCC   POWER
AH3   GND   GND
AH30  VCCP   POWER
AH31  out_data[184]   18_rtio_r50_lv   3010.1m  12.761nH  5.806pF
AH32  GND   GND
AH33  out_data[198]   18_rtio_r50_lv   2993.1m  12.274nH  5.841pF
AH34  timestamp[30]   18_rtio_r50_lv   3039.1m  13.164nH  5.960pF
AH35  out_data[224]   18_rtio_r50_lv   3011.5m  12.337nH  6.024pF
AH36  GND   GND
AH37  VCCR_GXBL1D   POWER
AH38  VCCR_GXBL1D   POWER
AH4   GND   GND
AH41  GND   GND
AH42  GND   GND
AH7   VCCR_GXBR4D   POWER
AH8   VCCR_GXBR4D   POWER
AH9   GND   GND
AJ1   GND   GND
AJ10  GND   GND
AJ11  out_data[125]   18_rtio_r50_lv   2951.0m  11.620nH  5.779pF
AJ12  out_data[105]   18_rtio_r50_lv   2826.2m  11.366nH  5.527pF
AJ13  out_data[126]   18_rtio_r50_lv   2811.8m  12.050nH  5.561pF
AJ14  out_data[91]   18_rtio_r50_lv   3148.4m  12.391nH  6.060pF
AJ15  GND   GND
AJ16  VCC   POWER
AJ17  VCC   POWER
AJ18  VCC   POWER
AJ19  VCC   POWER
AJ2   GND   GND
AJ20  GND   GND
AJ21  VCC   POWER
AJ22  VCCPT   POWER
AJ23  VCC   POWER
AJ24  VCC   POWER
AJ25  GND   GND
AJ26  VCC   POWER
AJ27  VCC   POWER
AJ28  VCC   POWER
AJ29  VCC   POWER
AJ30  GND   GND
AJ31  out_data[186]   18_rtio_r50_lv   3136.8m  13.092nH  6.100pF
AJ32  out_data[195]   18_rtio_r50_lv   3170.2m  13.394nH  6.152pF
AJ33  timestamp[31]   18_rtio_r50_lv   3060.3m  12.982nH  6.211pF
AJ34  in_ready   18_rtio_r50_lv   3050.1m  12.917nH  6.128pF
AJ35  GND   GND
AJ36  GND   GND
AJ39  GND   GND
AJ40  GND   GND
AJ43  GND   GND
AJ44  GND   GND
AJ5   GND   GND
AJ6   GND   GND
AJ9   GND   GND
AK10  GND   GND
AK11  out_data[130]   18_rtio_r50_lv   2121.7m  9.333nH   4.394pF
AK12  out_data[96]   18_rtio_r50_lv   2942.6m  11.692nH  5.725pF
AK13  GND   GND
AK14  out_data[114]   18_rtio_r50_lv   3151.1m  12.691nH  5.978pF
AK15  out_data[95]   18_rtio_r50_lv   2058.7m  8.440nH   4.270pF
AK16  VCC   POWER
AK17  VCC   POWER
AK18  GND   GND
AK19  VCC   POWER
AK20  VCC   POWER
AK21  VCCPGM   POWER
AK22  VCCPGM   POWER
AK23  GND   GND
AK24  VCC   POWER
AK26  VCC   POWER
AK27  VCC   POWER
AK28  GND   GND
AK29  VCC   POWER
AK3   GND   GND
AK31  in_data[230]   18_rtin_lv   2467.9m  10.738nH  4.859pF
AK32  in_data[239]   18_rtin_lv   2486.0m  10.703nH  4.848pF
AK33  VCCIO2I   POWER
AK34  in_data[202]   18_rtin_lv   2571.6m  10.763nH  5.143pF
AK35  GND   GND
AK36  VCCH_GXBL   POWER
AK37  VCCT_GXBL1C   POWER
AK38  VCCT_GXBL1C   POWER
AK4   GND   GND
AK41  GND   GND
AK42  GND   GND
AK7   VCCT_GXBR4C   POWER
AK8   VCCT_GXBR4C   POWER
AK9   VCCH_GXBR   POWER
AL1   GND   GND
AL10  out_data[124]   18_rtio_r50_lv   2163.8m  9.873nH   4.368pF
AL11  GND   GND
AL12  out_data[118]   18_rtio_r50_lv   3110.1m  12.531nH  5.992pF
AL13  out_data[122]   18_rtio_r50_lv   3121.2m  12.985nH  5.428pF
AL14  out_data[123]   18_rtio_r50_lv   2013.8m  8.792nH   3.786pF
AL15  out_data[94]   18_rtio_r50_lv   2025.0m  8.144nH   4.238pF
AL16  GND   GND
AL17  out_data[97]   18_rtio_r50_lv   2139.4m  8.634nH   4.441pF
AL18  out_data[86]   18_rtio_r50_lv   2469.3m  10.235nH  4.869pF
AL19  out_data[93]   18_rtio_r50_lv   2327.9m  9.670nH   4.730pF
AL2   GND   GND
AL20  out_data[116]   18_rtio_r50_lv   2298.1m  9.318nH   4.707pF
AL21  GND   GND
AL23  VCCBAT   POWER
AL26  GND   GND
AL31  VCCIO2I   POWER
AL32  in_data[7]   18_rtin_lv   2316.1m  11.312nH  4.732pF
AL33  in_data[9]   18_rtin_lv   2309.9m  10.771nH  4.713pF
AL34  in_data[3]   18_rtin_lv   2523.0m  10.482nH  4.967pF
AL35  GND   GND
AL36  GND   GND
AL39  GND   GND
AL40  GND   GND
AL43  GND   GND
AL44  GND   GND
AL5   GND   GND
AL6   GND   GND
AL9   GND   GND
AM10  GND   GND
AM11  out_data[132]   18_rtio_r50_lv   2128.1m  9.215nH   4.484pF
AM12  out_data[119]   18_rtio_r50_lv   2106.5m  8.879nH   4.454pF
AM13  out_data[110]   18_rtio_r50_lv   2239.7m  10.253nH  4.471pF
AM14  GND   GND
AM15  out_data[131]   18_rtio_r50_lv   1958.3m  8.245nH   4.136pF
AM16  out_data[117]   18_rtio_r50_lv   2123.4m  8.806nH   4.385pF
AM17  out_data[102]   18_rtio_r50_lv   2189.7m  9.285nH   4.454pF
AM18  out_data[85]   18_rtio_r50_lv   2484.6m  11.203nH  4.766pF
AM19  VCCIO3B   POWER
AM22  GND   GND
AM24  GND   GND
AM28  GND   GND
AM29  VCCIO2I   POWER
AM3   GND   GND
AM30  in_data[197]   18_rtin_lv   2771.7m  12.082nH  5.448pF
AM31  in_data[231]   18_rtin_lv   2303.6m  9.512nH   4.346pF
AM32  in_data[204]   18_rtin_lv   2266.5m  9.634nH   4.179pF
AM33  in_data[200]   18_rtin_lv   2073.8m  9.875nH   3.954pF
AM34  GND   GND
AM35  in_data[5]   18_rtin_lv   2142.2m  8.496nH   4.467pF
AM36  GND   GND
AM37  VCCR_GXBL1C   POWER
AM38  VCCR_GXBL1C   POWER
AM4   GND   GND
AM41  GND   GND
AM42  GND   GND
AM7   VCCR_GXBR4C   POWER
AM8   VCCR_GXBR4C   POWER
AM9   GND   GND
AN1   GND   GND
AN10  out_data[99]   18_rtio_r50_lv   1991.6m  8.875nH   3.794pF
AN11  out_data[108]   18_rtio_r50_lv   2019.7m  8.674nH   4.189pF
AN12  VCCIO3C   POWER
AN13  out_data[113]   18_rtio_r50_lv   2205.0m  10.255nH  4.497pF
AN14  out_data[111]   18_rtio_r50_lv   2126.0m  9.923nH   4.280pF
AN15  out_data[120]   18_rtio_r50_lv   2127.4m  9.803nH   4.214pF
AN16  out_data[90]   18_rtio_r50_lv   2162.0m  9.217nH   4.363pF
AN17  GND   GND
AN18  VREFB3BN0   POWER
AN19  in_data[221]   18_rtin_lv   840.6m   4.695nH   2.236pF
AN2   GND   GND
AN20  in_data[35]   18_rtin_lv   829.9m   4.333nH   2.284pF
AN22  GND   GND
AN23  VREFB3AN0   POWER
AN27  GND   GND
AN30  in_data[233]   18_rtin_lv   2757.3m  11.751nH  5.515pF
AN31  in_data[6]   18_rtin_lv   1784.9m  7.362nH   3.798pF
AN32  GND   GND
AN33  in_data[228]   18_rtin_lv   2067.2m  10.359nH  3.761pF
AN34  in_data[225]   18_rtin_lv   2176.4m  9.345nH   3.975pF
AN35  GND   GND
AN36  GND   GND
AN39  GND   GND
AN40  GND   GND
AN43  GND   GND
AN44  GND   GND
AN5   GND   GND
AN6   GND   GND
AN9   GND   GND
AP10  GND   GND
AP11  out_data[121]   18_rtio_r50_lv   2003.8m  8.645nH   3.909pF
AP12  out_data[172]   18_rtio_r50_lv   2380.1m  10.095nH  4.510pF
AP13  out_data[175]   18_rtio_r50_lv   2067.2m  9.206nH   4.271pF
AP14  out_data[137]   18_rtio_r50_lv   2071.8m  9.264nH   4.325pF
AP15  VCCIO3C   POWER
AP16  in_data[29]   18_rtin_lv   1810.9m  8.138nH   4.041pF
AP17  in_data[18]   18_rtin_lv   1836.5m  7.916nH   4.114pF
AP18  in_data[246]   18_rtin_lv   836.5m   4.475nH   2.262pF
AP19  in_data[33]   18_rtin_lv   836.9m   4.560nH   2.300pF
AP20  VCCIO3B   POWER
AP21  in_data[217]   18_rtin_lv   1026.3m  5.376nH   2.604pF
AP22  out_data[220]   18_rtio_r50_lv   931.8m   4.339nH   2.515pF
AP23  out_data[222]   18_rtio_r50_lv   941.8m   4.375nH   2.492pF
AP24  out_keep[22]   18_rtio_r50_lv   877.0m   4.056nH   2.473pF
AP25  GND   GND
AP26  out_keep[25]   18_rtio_r50_lv   1016.4m  4.530nH   2.710pF
AP28  in_data[173]   18_rtin_lv   889.7m   4.410nH   2.365pF
AP3   GND   GND
AP30  GND   GND
AP31  in_data[70]   18_rtin_lv   1792.0m  7.274nH   3.904pF
AP32  in_data[4]   18_rtin_lv   2258.6m  10.215nH  4.407pF
AP33  in_data[207]   18_rtin_lv   2039.9m  9.208nH   3.782pF
AP34  in_data[229]   18_rtin_lv   2029.3m  9.014nH   3.727pF
AP35  GND   GND
AP36  GND   GND
AP37  GND   GND
AP38  GND   GND
AP4   GND   GND
AP41  GND   GND
AP42  GND   GND
AP7   GND   GND
AP8   GND   GND
AP9   GND   GND
AR1   GND   GND
AR10  out_data[100]   18_rtio_r50_lv   1989.3m  8.130nH   4.253pF
AR11  out_data[135]   18_rtio_r50_lv   2390.3m  10.156nH  4.590pF
AR12  out_data[146]   18_rtio_r50_lv   2372.9m  10.566nH  4.506pF
AR13  VCCIO3C   POWER
AR14  in_data[215]   18_rtin_lv   1860.8m  7.967nH   4.093pF
AR15  in_data[244]   18_rtin_lv   1827.8m  7.489nH   4.110pF
AR16  in_data[27]   18_rtin_lv   1809.8m  7.915nH   4.058pF
AR17  in_data[208]   18_rtin_lv   1811.1m  7.918nH   3.990pF
AR18  VCCIO3B   POWER
AR19  in_data[34]   18_rtin_lv   913.4m   4.593nH   2.374pF
AR2   GND   GND
AR20  in_data[22]   18_rtin_lv   892.2m   4.801nH   2.428pF
AR21  in_data[212]   18_rtin_lv   1045.7m  5.277nH   2.694pF
AR22  in_data[16]   18_rtin_lv   934.7m   4.778nH   2.475pF
AR23  VCCIO3A   POWER
AR24  out_data[246]   18_rtio_r50_lv   898.6m   4.145nH   2.522pF
AR25  out_keep[28]   18_rtio_r50_lv   1016.8m  4.512nH   2.698pF
AR26  out_data[221]   18_rtio_r50_lv   1011.8m  4.716nH   2.686pF
AR28  VCCIO2A   POWER
AR30  VREFB2IN0   POWER
AR31  in_data[8]   18_rtin_lv   1859.5m  7.973nH   3.867pF
AR32  in_data[13]   18_rtin_lv   2244.0m  9.647nH   4.588pF
AR33  GND   GND
AR34  in_data[196]   18_rtin_lv   1958.8m  9.163nH   3.617pF
AR35  in_data[236]   18_rtin_lv   1962.2m  10.195nH  3.563pF
AR36  in_data[194]   18_rtin_lv   2097.6m  9.606nH   4.224pF
AR37  in_data[195]   18_rtin_lv   2060.7m  9.391nH   4.130pF
AR38  GND   GND
AR39  GND   GND
AR40  GND   GND
AR43  GND   GND
AR44  GND   GND
AR5   GND   GND
AR6   GND   GND
AR7   GND   GND
AR8   GND   GND
AR9   out_data[173]   18_rtio_r50_lv   2242.8m  9.650nH   4.696pF
AT10  out_data[136]   18_rtio_r50_lv   2391.5m  10.162nH  4.656pF
AT11  GND   GND
AT12  VREFB3CN0   POWER
AT13  out_data[154]   18_rtio_r50_lv   1989.2m  8.751nH   4.276pF
AT14  in_data[222]   18_rtin_lv   1889.4m  8.232nH   4.139pF
AT15  in_data[240]   18_rtin_lv   1858.8m  7.790nH   4.115pF
AT16  GND   GND
AT17  in_data[243]   18_rtin_lv   1679.0m  8.047nH   3.698pF
AT18  in_data[32]   18_rtin_lv   1824.3m  8.117nH   3.984pF
AT19  in_data[220]   18_rtin_lv   963.4m   4.718nH   2.517pF
AT20  in_data[214]   18_rtin_lv   944.5m   4.407nH   2.515pF
AT21  GND   GND
AT22  in_data[211]   18_rtin_lv   949.0m   4.731nH   2.579pF
AT23  out_valid   18_rtio_r50_lv   884.4m   4.309nH   2.407pF
AT24  out_data[223]   18_rtio_r50_lv   907.3m   4.236nH   2.493pF
AT25  timestamp_valid   18_rtio_r50_lv   1041.7m  4.678nH   2.767pF
AT26  GND   GND
AT27  VREFB2AN0   POWER
AT28  in_data[160]   18_rtin_lv   1160.7m  5.946nH   2.800pF
AT29  in_data[165]   18_rtin_lv   1163.1m  5.600nH   2.890pF
AT3   GND   GND
AT30  in_data[237]   18_rtin_lv   1863.8m  7.875nH   3.956pF
AT31  GND   GND
AT32  in_data[238]   18_rtin_lv   1886.8m  9.207nH   3.850pF
AT33  in_data[193]   18_rtin_lv   1899.8m  8.690nH   3.402pF
AT34  in_data[199]   18_rtin_lv   2054.8m  8.335nH   4.392pF
AT35  in_data[203]   18_rtin_lv   2099.3m  8.825nH   4.307pF
AT36  GND   GND
AT37  in_data[201]   18_rtin_lv   2444.3m  10.719nH  4.771pF
AT38  GND   GND
AT4   GND   GND
AT41  GND   GND
AT42  GND   GND
AT7   GND   GND
AT8   out_data[155]   18_rtio_r50_lv   2305.3m  9.856nH   4.852pF
AT9   out_data[179]   18_rtio_r50_lv   2248.8m  9.786nH   4.612pF
AU1   GND   GND
AU10  out_data[160]   18_rtio_r50_lv   2166.7m  9.302nH   4.546pF
AU11  out_data[180]   18_rtio_r50_lv   1999.5m  9.198nH   3.793pF
AU12  out_data[142]   18_rtio_r50_lv   1981.0m  8.947nH   3.699pF
AU13  out_data[148]   18_rtio_r50_lv   2003.9m  8.336nH   4.319pF
AU14  GND   GND
AU15  in_data[14]   18_rtin_lv   1401.6m  6.339nH   2.955pF
AU16  in_data[216]   18_rtin_lv   1338.2m  6.016nH   3.207pF
AU17  in_data[20]   18_rtin_lv   1658.6m  7.350nH   3.776pF
AU18  in_data[19]   18_rtin_lv   1852.2m  8.502nH   4.111pF
AU19  GND   GND
AU2   GND   GND
AU20  in_data[209]   18_rtin_lv   1313.1m  6.167nH   3.200pF
AU21  in_data[223]   18_rtin_lv   1478.4m  6.745nH   3.457pF
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| Models and submodels in the file (2): 18_rtin_lv (Input), 18_rtio_r50_lv (I/O)
